ADE simulation setup
Run mode: Single Run, Sweeps and Corners
Tests:
  EEE_234_Project1:4Bit_Adder_TB:1: EEE_234_Project1/4Bit_Adder_TB/schematic, simulator spectre
